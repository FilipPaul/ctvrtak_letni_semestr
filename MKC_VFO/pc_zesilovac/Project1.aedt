# Ansys Electronics Desktop project, version 2021.2
materials:
  copper: permeability=0.999991 conductivity=58000000
  FR4_epoxy: permittivity=4.4 dielectric_loss_tangent=0.02

design Circuit1 (Circuit)
options: SParamCircuitDef IntegrationMethod=FFT
variables:
  Lx = 0H  # tune 0H..30nH
  Rx = 0ohm  # tune 0ohm..400ohm
  Cx = 0pF  # tune 0pF..30nF
components:
  S21 = BFP196W_w_noise_VCE_3()
  L43 = IND_(L=Lx)
  C44 = CAP_(C=Cx)
  C47 = CAP_(C=18.33pF)  # Inactive_Short
  L48 = IND_(L=10.53nH)  # Inactive_Open
  port Port1 rz=50ohm iz=0ohm EnableNoise=false noisetemp=16.85cel
  port Port2 rz=50ohm iz=0ohm EnableNoise=false noisetemp=16.85cel
nets:
  0: S21.ref, L48.1, L43.1
  net_10: S21.0, C44.1
  Port1: L43.0, C44.0
  Port2: C47.1, L48.0
  Port3: S21.1, C47.0
setups:
  LinearFrequency: LinearFrequencyData(false, 0.1, true, "", false) SweepDefinition{Variable=Freq Data="LIN 1GHz 3GHz 10MHz"}
reports:
  S Parameter Plot 1: dB(S(Port1,Port1)), dB(S(Port1,Port1)), dB(S(Port2,Port1)), dB(S(Port2,Port2)), dB(GMAX), dB(MSG) vs Freq on LinearFrequency : LinearFrequency; markers MX1 at x=2.4014981e+09
  S Parameter Chart 1: S(Port1,Port1), S(Port2,Port2) on LinearFrequency : LinearFrequency [Freq=all]; markers m1 at 2.4GHz, m2 at 2.37GHz
  S-Parameters: S(Port1,Port1) on LinearFrequency : LinearFrequency [Freq=all]; GPCS(gain=15dB), RHOL(gamma=-0.649-j0.104 gain=15dB), GACL(gain=15dB), GACS(gain=15dB) on LinearFrequency : LinearFrequency [Freq=1GHz]
