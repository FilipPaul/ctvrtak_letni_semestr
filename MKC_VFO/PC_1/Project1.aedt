# Ansys Electronics Desktop project, version 2021.2
materials:
  copper: permeability=0.999991 conductivity=58000000
  FR4_epoxy: permittivity=4.4 dielectric_loss_tangent=0.02

design Circuit1 (Circuit)
options: SParamCircuitDef IntegrationMethod=FFT
variables:
  C1 = 0.9448farad
  C3 = 1.4415farad
  C2 = 0.2694farad
  C4 = 0.8827farad
  C5 = 0.604farad
  L1 = 1.106H
  L2 = 0.6829H
  Rin = 50ohm
  f3db = 147MHz
components:
  A1 = CAP_Q(c=C1)
  A2 = IND_Q(L=L1)
  A3 = CAP_Q(c=C2)
  A4 = CAP_Q(c=C3)
  A5 = CAP_Q(c=C4)
  A6 = IND_Q(L=L2)
  A7 = CAP_Q(c=C5)
  A8 = CAP_Q(c=C1/(2*pi*f3db*Rin))
  A9 = IND_Q(L=L1*Rin/(2*pi*f3db))
  A10 = CAP_Q(c=C2/(2*pi*f3db*Rin))
  A11 = CAP_Q(c=C3/(2*pi*f3db*Rin))
  A12 = CAP_Q(c=C4/(2*pi*f3db*Rin))
  A13 = IND_Q(L=L2*Rin/(2*pi*f3db))
  A14 = CAP_Q(c=C5/(2*pi*f3db*Rin))
  A15 = CAP_Q(c=2.2e-11)
  A16 = IND_Q(L=5.6e-08 Q=60)
  A17 = CAP_Q(c=6.8e-12)
  A18 = CAP_Q(c=3.3e-11)
  A20 = IND_Q(L=3.6e-08 Q=60)
  A21 = CAP_Q(c=1e-11)
  A19 = CAP_Q(c=1e-11)
  A22 = CAP_Q(c=1e-11)
  A23 = CAP_Q(c=1.5e-12)
  port P_REAL_1 rz=Rin iz=0ohm EnableNoise=false noisetemp=16.85cel
  port P_REAL_2 rz=Rin iz=0ohm EnableNoise=false noisetemp=16.85cel
  port Port1 rz=1ohm iz=0ohm EnableNoise=false noisetemp=16.85cel
  port Port11 rz=Rin iz=0ohm EnableNoise=false noisetemp=16.85cel
  port Port2 rz=1ohm iz=0ohm EnableNoise=false noisetemp=16.85cel
  port Port22 rz=Rin iz=0ohm EnableNoise=false noisetemp=16.85cel
nets:
  0: A7.1, A8.1, A4.1, A1.1, A11.1, A14.1, A18.1, A15.1, A21.1
  net_1: A9.1, A10.1, A13.0, A11.0, A12.0
  net_2: A2.1, A3.1, A4.0, A6.0, A5.0
  net_3: A17.1, A16.1, A19.0, A18.0, A20.0, A22.0, A23.1
  P_REAL_1: A17.0, A16.0, A15.0, A23.0
  P_REAL_2: A19.1, A20.1, A21.0, A22.1
  Port1: A2.0, A3.0, A1.0
  Port11: A8.0, A9.0, A10.0
  Port2: A7.0, A6.1, A5.1
  Port22: A13.1, A12.1, A14.0
setups:
  LinearFrequency: LinearFrequencyData(false, 0.1, false, "", false) SweepDefinition{Variable=Freq Data="DEC 0.1Hz 10GHz 1000"}
reports:
  S Parameter Plot 1: dB(S(Port1,Port1)), dB(S(Port2,Port1)) vs Freq on LinearFrequency : LinearFrequency; markers m1 at 1.7060824e-10GHz, m2 at 1.981527e-10GHz
  S Parameter Plot 2: dB(S(Port11,Port11)), dB(S(Port22,Port11)), dB(S(P_REAL_1,P_REAL_1)), dB(S(P_REAL_2,P_REAL_1)) vs Freq on LinearFrequency : LinearFrequency; markers m1 at 0.15703628GHz, m2 at 0.18793168GHz, m3 at 206.06299MHz
