# Ansys Electronics Desktop project, version 2021.2
materials:
  copper: permeability=0.999991 conductivity=58000000
  FR4_epoxy: permittivity=4.4 dielectric_loss_tangent=0.02

design Circuit1 (Circuit)
options: SParamCircuitDef IntegrationMethod=FFT
variables:
  L1 = 1.5e-09H  # tune 0H..1e-08H
components:
  S1 = ne68133i()
  L3 = IND_(L=L1)
  U14 = Circuit2()
  U18 = Circuit3()
  port Port1 rz=50ohm iz=0ohm EnableNoise=false noisetemp=16.85cel
  port Port2 rz=50ohm iz=0ohm EnableNoise=false noisetemp=16.85cel
nets:
  0: L3.0
  net_3: S1.ref, L3.1
  net_7: S1.Port1, U14.1
  net_8: S1.Port2, U18.0
  Port1: U14.0
  Port2: U18.1
setups:
  LinearFrequency: LinearFrequencyData(false, 0.1, true, "", false) SweepDefinition{Variable=Freq Data="LIN 500MHz 1.5GHz 10MHz"}
reports:
  S Parameter Plot 1: dB(S(Port1,Port1)), dB(S(Port2,Port1)), dB(S(Port1,Port2)), dB(S(Port2,Port2)), dB(MSG), dB(GMAX), dB(FMIN), dB(NF), K, B1 vs Freq on LinearFrequency : LinearFrequency; markers MX1 at x=9.0332907e+08
  S Parameter Chart 1: S(Port1,Port1), S(Port2,Port2) on LinearFrequency : LinearFrequency [Freq=all]
  S-Parameters: S(Port1,Port1) on LinearFrequency : LinearFrequency [Freq=all]
  S-Parameters1: S(Port1,Port1) on LinearFrequency : LinearFrequency [Freq=all]; GACS(gain=12dB), NC(value=1.5dB), RHOL(gamma=-0.339+j0.279 gain=12dB), GACL(gain=12dB), GACS(gain=12dB) on LinearFrequency : LinearFrequency [Freq=0.9GHz]

design Circuit2 (Circuit)
options: SParamCircuitDef IntegrationMethod=FFT
components:
  L15 = IND_(L=7.62nH)
  C16 = CAP_(C=17.78pF)
  port Port1 rz=50ohm iz=0ohm EnableNoise=false noisetemp=16.85cel
  port Port2 rz=50ohm iz=0ohm EnableNoise=false noisetemp=16.85cel
nets:
  0: L15.1
  Port1: L15.0, C16.0
  Port2: C16.1

design Circuit3 (Circuit)
options: SParamCircuitDef IntegrationMethod=FFT
components:
  L19 = IND_(L=12.73nH)
  C20 = CAP_(C=1.6pF)
  port Port1 rz=50ohm iz=0ohm EnableNoise=false noisetemp=16.85cel
  port Port2 rz=50ohm iz=0ohm EnableNoise=false noisetemp=16.85cel
nets:
  0: L19.1
  Port1: L19.0, C20.0
  Port2: C20.1
