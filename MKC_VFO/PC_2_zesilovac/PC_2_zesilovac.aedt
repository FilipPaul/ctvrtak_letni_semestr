# Ansys Electronics Desktop project, version 2021.2
materials:
  copper: permeability=0.999991 conductivity=58000000
  FR4_epoxy: permittivity=4.4 dielectric_loss_tangent=0.02

design Circuit1 (Circuit)
options: SParamCircuitDef IntegrationMethod=FFT
variables:
  Lx = 2nH  # tune 0nH..100nH
  Rx = 340ohm  # tune 0ohm..300ohm
  Lin = 14.7nH  # tune 51.73nH..155.19nH
  Cin = 14.2pF  # tune 33.345pF..100.035pF
  Lout = 32.2nH  # tune 0nH..50nH
  Cout_2 = 100nF  # tune 0nF..150nF
  Cout = 20nF  # tune 0nF..100nF
components:
  S1 = BFP196W_w_noise_VCE_3()
  R2 = RES_(R=200)
  R3 = RES_(R=1100)
  R4 = RES_(R=13300)
  R5 = RES_(R=4700)
  R6 = RES_(R=10)
  R7 = RES_(R=1100)
  C10 = CAP_(C=100nF)
  C1 = CAP_(C=1nF)
  L15 = IND_(L=Lx)
  R1 = RES_(R=Rx)
  L24 = IND_(L=Lin)
  C25 = CAP_(C=Cin)
  C2 = CAP_(C=Cout)
  L1 = IND_(L=Lout)
  C3 = CAP_(C=Cout_2)  # Inactive_Short
  port Port1 rz=50ohm iz=0ohm EnableNoise=false noisetemp=16.85cel
  port Port2 rz=50ohm iz=0ohm EnableNoise=false noisetemp=16.85cel
nets:
  0: R7.0, R6.0, C3.0, C10.1, C1.1, L24.1, R1.1, L15.0
  net_1: R3.1, R5.0, R7.1
  net_2: R2.1, R3.0, R6.1, C10.0
  net_3: R5.1, R4.0, C1.0
  net_4: S1.ref, L15.1
  net_6: S1.Port1, R4.1, C25.1
  net_7: L1.1, C3.1
  net_8: S1.Port2, R2.0, C2.0
  Port1: L24.0, C25.0
  Port2: C2.1, L1.0, R1.0
setups:
  LinearFrequency: LinearFrequencyData(false, 0.1, true, "", false) SweepDefinition{Variable=Freq Data="LIN 0.1GHz 1GHz 0.001GHz"}
reports:
  S Parameter Plot 1: dB(S(Port1,Port1)), dB(S(Port2,Port1)), dB(S(Port1,Port2)), dB(S(Port2,Port2)), dB(MSG), dB(GMAX) vs Freq on LinearFrequency : LinearFrequency; markers MX1 at x=6.0255265e+08
  Stability Plot 1: B1, K, dB(FMIN), dB(NF) vs Freq on LinearFrequency : LinearFrequency; markers MX1 at x=6.026552e+08, MX2 at x=1.0039698e+08
  S Parameter Chart 1: S(Port1,Port1) on LinearFrequency : LinearFrequency [Freq=all]
  S-Parameters: S(Port1,Port1) on LinearFrequency : LinearFrequency [Freq=all]; KCS, KCL on LinearFrequency : LinearFrequency [Freq=0.1GHz]; markers m1 at 0.603GHz
  S-Parameters1: S(Port1,Port1), S(Port2,Port2) on LinearFrequency : LinearFrequency [Freq=all]; markers m1 at 0.596GHz, m2 at 0.586GHz
  S-Parameters2: S(Port1,Port1) on LinearFrequency : LinearFrequency [Freq=all]; GPCS(gain=25dB) on LinearFrequency : LinearFrequency [Freq=0.1GHz]

design Circuit2 (Circuit)
options: SParamCircuitDef IntegrationMethod=FFT
variables:
  Lx = 2nH  # tune 0nH..100nH
  Rx = 340ohm  # tune 0ohm..300ohm
  Lin = 14.7nH  # tune 51.73nH..155.19nH
  Cin = 14.2pF  # tune 33.345pF..100.035pF
  Lout = 32.2nH  # tune 0nH..50nH
  Cout_2 = 100nF  # tune 0nF..150nF
  Cout = 20nF  # tune 0nF..100nF
  diam = 0.2mm  # tune 0.1mm..0.3mm
components:
  S1 = BFP196W_w_noise_VCE_3()
  R2 = RES_(R=200)
  R3 = RES_(R=1100)
  R4 = RES_(R=13200)
  R5 = RES_(R=4700)
  R6 = RES_(R=10)
  R7 = RES_(R=1100)
  C10 = CAP_(C=100nF)
  C1 = CAP_(C=1nF)
  R1 = RES_(R=330)
  C25 = CAP_(C=15p)
  C2 = CAP_(C=22n)
  A42 = IND_Q(L=15n Q=50)
  A1 = IND_Q(L=33n Q=50)
  L15 = IND_(L=Lx)
  port Port1 rz=50ohm iz=0ohm EnableNoise=false noisetemp=16.85cel
  port Port2 rz=50ohm iz=0ohm EnableNoise=false noisetemp=16.85cel
nets:
  0: C1.1, R6.0, R1.1, C10.1, R7.0, A42.0, A1.0, L15.0
  net_1: R5.0, R3.1, R7.1
  net_11: S1.ref, L15.1
  net_2: R6.1, R3.0, C10.0, R2.1
  net_3: C1.0, R4.0, R5.1
  net_6: C25.1, S1.Port1, R4.1
  net_8: C2.0, S1.Port2, R2.0
  Port1: C25.0, A42.1
  Port2: C2.1, R1.0, A1.1
setups:
  LinearFrequency: LinearFrequencyData(false, 0.1, true, "", false) SweepDefinition{Variable=Freq Data="LIN 0.1GHz 1GHz 0.001GHz"}
reports:
  S Parameter Plot 1: dB(S(Port1,Port1)), dB(S(Port2,Port1)), dB(S(Port1,Port2)), dB(S(Port2,Port2)), dB(MSG), dB(GMAX) vs Freq on LinearFrequency : LinearFrequency; markers MX1 at x=5.9993434e+08
  Stability Plot 1: B1, K, dB(FMIN), dB(NF) vs Freq on LinearFrequency : LinearFrequency; markers MX1 at x=6.026552e+08, MX2 at x=1.0039698e+08
  S Parameter Chart 1: S(Port1,Port1) on LinearFrequency : LinearFrequency [Freq=all]
  S-Parameters: S(Port1,Port1) on LinearFrequency : LinearFrequency [Freq=all]; KCS, KCL on LinearFrequency : LinearFrequency [Freq=0.1GHz]; markers m1 at 0.603GHz
  S-Parameters1: S(Port1,Port1), S(Port2,Port2) on LinearFrequency : LinearFrequency [Freq=all]; markers m1 at 0.596GHz, m2 at 0.586GHz
  S-Parameters2: S(Port1,Port1) on LinearFrequency : LinearFrequency [Freq=all]; GPCS(gain=25dB) on LinearFrequency : LinearFrequency [Freq=0.1GHz]
