# Ansys Electronics Desktop project, version 2021.2
materials:
  copper: permeability=0.999991 conductivity=58000000
  FR4_epoxy: permittivity=4.4 dielectric_loss_tangent=0.02

design Circuit1 (Circuit)
options: SParamCircuitDef IntegrationMethod=FFT
variables:
  Lx = 3e-10H  # tune 0H..5nH
  RX = 104ohm  # tune 0ohm..250ohm
components:
  S1 = BFP720ESD_w_noise_VCE_3()
  L2 = IND_(L=Lx)
  R3 = RES_(R=RX)  # Inactive_Short
  R1 = RES_(R=RX)
  C9 = CAP_(C=1.36pF)
  L10 = IND_(L=4.4nH)
  C1 = CAP_(C=100pF)
  port Port1 rz=50ohm iz=0ohm EnableNoise=false noisetemp=16.85cel
  port Port2 rz=50ohm iz=0ohm EnableNoise=false noisetemp=16.85cel
nets:
  0: R1.1, L2.0, C1.0
  net_1: L2.1, S1.ref
  net_2: R1.0, R3.1, S1.1
  net_6: L10.1, C9.1, S1.0
  net_7: L10.0, C1.1
  Port1: C9.0
  Port2: R3.0
setups:
  LinearFrequency: LinearFrequencyData(false, 0.1, true, "", false) SweepDefinition{Variable=Freq Data="LIN 50MHz 3.5GHz 50MHz"}
reports:
  S Parameter Plot 1: dB(S(Port1,Port1)), dB(S(Port2,Port1)), dB(GMAX), dB(MSG) vs Freq on LinearFrequency : LinearFrequency; markers MX1 at x=2.4005622e+09
  S Parameter Chart 1: S(Port1,Port1), S(Port2,Port2) on LinearFrequency : LinearFrequency [Freq=all]
  S-Parameters: S(Port1,Port1) on LinearFrequency : LinearFrequency [Freq=all]; KCL, KCS on LinearFrequency : LinearFrequency [Freq=2.4GHz]
  S-Parameters1: S(Port1,Port1) on LinearFrequency : LinearFrequency [Freq=all]; NC(value=0.75dB), GACS(gain=15.7dB) on LinearFrequency : LinearFrequency [Freq=2400MHz]
  S Parameter Plot 1_1: dB(FMIN), dB(NF) vs Freq on LinearFrequency : LinearFrequency; markers MX1 at x=2.4005622e+09
  S-Parameters2: S(Port1,Port1) on LinearFrequency : LinearFrequency [Freq=all]
